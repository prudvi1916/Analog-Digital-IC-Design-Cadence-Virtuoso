ADE simulation setup
Run mode: Single Run, Sweeps and Corners
Tests:
  Poli_analog:Nor_tb:1: Poli_analog/Nor_tb/schematic, simulator spectre
