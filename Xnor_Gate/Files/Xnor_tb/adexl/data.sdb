ADE simulation setup
Run mode: Single Run, Sweeps and Corners
Tests:
  Poli_analog:Xnor_tb:1: Poli_analog/Xnor_tb/schematic, simulator spectre
