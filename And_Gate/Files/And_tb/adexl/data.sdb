ADE simulation setup
Run mode: Single Run, Sweeps and Corners
Tests:
  Poli_analog:And_tb:1: Poli_analog/And_tb/schematic, simulator spectre
