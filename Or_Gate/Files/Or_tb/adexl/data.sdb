ADE simulation setup
Run mode: Single Run, Sweeps and Corners
Tests:
  Poli_analog:Or_tb:1: Poli_analog/Or_tb/schematic, simulator spectre
