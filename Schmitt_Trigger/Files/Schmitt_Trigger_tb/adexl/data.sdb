ADE simulation setup
Run mode: Single Run, Sweeps and Corners
Tests:
  Poli_analog:Schmitt_Trigger_tb:1: Poli_analog/Schmitt_Trigger_tb/schematic, simulator spectre
