ADE simulation setup
Run mode: Single Run, Sweeps and Corners
Tests:
  Poli_analog:Xor_tb:1: Poli_analog/Xor_tb/schematic, simulator spectre
