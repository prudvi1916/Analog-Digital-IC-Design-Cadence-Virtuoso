ADE simulation setup
Run mode: Single Run, Sweeps and Corners
Tests:
  Poli_analog:Two_Stage_Analog_Comparator_tb:1: Poli_analog/Two_Stage_Analog_Comparator_tb/schematic, simulator spectre
