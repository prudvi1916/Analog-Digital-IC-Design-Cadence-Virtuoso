ADE simulation setup
Run mode: Single Run, Sweeps and Corners
Tests:
  Poli_analog:Nand_tb:1: Poli_analog/Nand_tb/schematic, simulator spectre
